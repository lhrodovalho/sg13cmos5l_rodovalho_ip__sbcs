** sch_path: /foss/designs/sg13cmos5l_rodovalho_ip__sbcs/xschem/tb_sbcs_tran.sch
**.subckt tb_sbcs_tran
Xdut o avss avdd avss en enb sbcs
v_avss GND avss xavss
v_avdd avdd avss dc {xavdd}
v_en en avss {xen*xavdd} pwl( 0 0 1u 0 1.1u {xavdd} 19u {xavdd} 19.1u 0)
v_enb enb avss {(1-xen)*xavdd} pwl( 0 {xavdd} 1u {xavdd} 1.1u 0 19u 0 19.1u {xavdd})

v_o o avss dc {xvo}
**** begin user architecture code

.lib $PDK_ROOT/$PDK/libs.tech/ngspice/models/cornerMOShv.lib mos_tt

.option cshunt = 1e-15
.option gmin   = 1e-10
.control
  pre_osdi .lib $PDK_ROOT/$PDK/libs.tech/ngspice/models/osdi/psp103_nqs.osdi

  tran 10n 20u 10n uic
  let io = i(v_o)
  plot io ylimit 0 5u
.endc

.param xavdd = 3.3
.param xavss = 0
.param xvo   = 0
.param xen   = 1

**** end user architecture code
**.ends

* expanding   symbol:  sbcs.sym # of pins=7
** sym_path: /foss/designs/sg13cmos5l_rodovalho_ip__sbcs/xschem/sbcs.sym
** sch_path: /foss/designs/sg13cmos5l_rodovalho_ip__sbcs/xschem/sbcs.sch
.subckt sbcs iop ion avdd avss en enb
*.iopin avdd
*.iopin avss
*.iopin iop
*.iopin ion
*.iopin vsub
*.ipin en
*.ipin enb
Xslice[1] iop ion avdd avss en enb bp0 bp bn sbcs_slice
Xslice[0] iop ion avdd avss en enb bp0 bp bn sbcs_slice
cc bp0 bn 1.0p
.ends

* expanding   symbol:  sbcs_slice.sym # of pins=10
** sym_path: /foss/designs/sg13cmos5l_rodovalho_ip__sbcs/xschem/sbcs_slice.sym
** sch_path: /foss/designs/sg13cmos5l_rodovalho_ip__sbcs/xschem/sbcs_slice.sch
.subckt sbcs_slice iop ion avdd avss en enb bp0 bp bn
*.iopin avdd
*.iopin avss
*.iopin iop
*.iopin ion
*.iopin bp0
*.iopin bp
*.iopin bn
*.iopin vsub
*.ipin en
*.ipin enb
x0a[1] x bp avdd avdd p2_2
x0a[0] x bp avdd avdd p2_2
x1a[1] bn0 bp avdd avdd p1_4
x1a[0] bn0 bp avdd avdd p1_4
x2a[1] bn bp avdd avdd p1_4
x2a[0] bn bp avdd avdd p1_4
x4a[1] bp0 bp avdd avdd p1_4
x4a[0] bp0 bp avdd avdd p1_4
x5a[1] iop bp avdd avdd p2_2
x5a[0] iop bp avdd avdd p2_2
x0d[1] x x y0 avss n2_1
x0d[0] x x y0 avss n2_1
x0e[3] y0 x avss avss n1_2
x0e[2] y0 x avss avss n1_2
x0e[1] y0 x avss avss n1_2
x0e[0] y0 x avss avss n1_2
x1d[1] bn0 bn0 y0 avss n2_1
x1d[0] bn0 bn0 y0 avss n2_1
x2d[1] bn bn0 y1 avss n2_1
x2d[0] bn bn0 y1 avss n2_1
x2e[1] y1 bn0 avss avss n1_2
x2e[0] y1 bn0 avss avss n1_2
x4d[1] bp0 bn y2 avss n2_1
x4d[0] bp0 bn y2 avss n2_1
x4e[1] y2 bn avss avss n1_2
x4e[0] y2 bn avss avss n1_2
x5e[1] ion bn avss avss n2_2
x5e[0] ion bn avss avss n2_2
x3a[1] bp en avdd avdd p1_1
x3a[0] bp en avdd avdd p1_1
x3c[1] bp0 enb avss avss n1_1
x3c[0] bp0 enb avss avss n1_1
x3e[1] bn enb avss avss n1_1
x3e[0] bn enb avss avss n1_1
x3b[1] bp0 enb bp avdd p1_1
x3b[0] bp0 enb bp avdd p1_1
.ends

* expanding   symbol:  p2_2.sym # of pins=4
** sym_path: /foss/designs/sg13cmos5l_rodovalho_ip__sbcs/xschem/p2_2.sym
** sch_path: /foss/designs/sg13cmos5l_rodovalho_ip__sbcs/xschem/p2_2.sch
.subckt p2_2 D G S B
*.iopin D
*.iopin G
*.iopin S
*.iopin B
xl D G S B p1_2
xr D G S B p1_2
.ends

* expanding   symbol:  p1_4.sym # of pins=4
** sym_path: /foss/designs/sg13cmos5l_rodovalho_ip__sbcs/xschem/p1_4.sym
** sch_path: /foss/designs/sg13cmos5l_rodovalho_ip__sbcs/xschem/p1_4.sch
.subckt p1_4 D G S B
*.iopin D
*.iopin G
*.iopin S
*.iopin B
xs X G S B p1_2
xd D G X B p1_2
.ends

* expanding   symbol:  n2_1.sym # of pins=4
** sym_path: /foss/designs/sg13cmos5l_rodovalho_ip__sbcs/xschem/n2_1.sym
** sch_path: /foss/designs/sg13cmos5l_rodovalho_ip__sbcs/xschem/n2_1.sch
.subckt n2_1 D G S B
*.iopin D
*.iopin G
*.iopin S
*.iopin B
xr D G S B n1_1
xl D G S B n1_1
.ends

* expanding   symbol:  n1_2.sym # of pins=4
** sym_path: /foss/designs/sg13cmos5l_rodovalho_ip__sbcs/xschem/n1_2.sym
** sch_path: /foss/designs/sg13cmos5l_rodovalho_ip__sbcs/xschem/n1_2.sch
.subckt n1_2 D G S B
*.iopin D
*.iopin G
*.iopin S
*.iopin B
xd D G X B n1_1
xs X G S B n1_1
.ends

* expanding   symbol:  n2_2.sym # of pins=4
** sym_path: /foss/designs/sg13cmos5l_rodovalho_ip__sbcs/xschem/n2_2.sym
** sch_path: /foss/designs/sg13cmos5l_rodovalho_ip__sbcs/xschem/n2_2.sch
.subckt n2_2 D G S B
*.iopin D
*.iopin G
*.iopin S
*.iopin B
xr D G S B n1_2
xl D G S B n1_2
.ends

* expanding   symbol:  p1_1.sym # of pins=4
** sym_path: /foss/designs/sg13cmos5l_rodovalho_ip__sbcs/xschem/p1_1.sym
** sch_path: /foss/designs/sg13cmos5l_rodovalho_ip__sbcs/xschem/p1_1.sch
.subckt p1_1 D G S B
*.iopin D
*.iopin G
*.iopin S
*.iopin B
**** begin user architecture code

X0 d g s b sg13_hv_pmos W=4.5u L=2.5u ng=1

**** end user architecture code
.ends

* expanding   symbol:  n1_1.sym # of pins=4
** sym_path: /foss/designs/sg13cmos5l_rodovalho_ip__sbcs/xschem/n1_1.sym
** sch_path: /foss/designs/sg13cmos5l_rodovalho_ip__sbcs/xschem/n1_1.sch
.subckt n1_1 D G S B
*.iopin D
*.iopin G
*.iopin S
*.iopin B
**** begin user architecture code

X0 d g s b sg13_hv_nmos W=4.5u L=2.5u ng=1

**** end user architecture code
.ends

* expanding   symbol:  p1_2.sym # of pins=4
** sym_path: /foss/designs/sg13cmos5l_rodovalho_ip__sbcs/xschem/p1_2.sym
** sch_path: /foss/designs/sg13cmos5l_rodovalho_ip__sbcs/xschem/p1_2.sch
.subckt p1_2 D G S B
*.iopin D
*.iopin G
*.iopin S
*.iopin B
xs X G S B p1_1
xd D G X B p1_1
.ends

.GLOBAL GND
.end
